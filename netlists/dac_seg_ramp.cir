* dac_seg_ramp
.include cmos180_approx.lib
.options savecurrents=0

.temp 27.0
VDD vdd 0 dc 1.8
Vcas vcas 0 dc 1.2
Iref vdd vbn dc 4e-06
Mref vbn vbn 0 0 nch w=1.5e-06 l=6e-06 m=1 delvto=0 mulu0=1
RLp vdd outp 400.0
RLn vdd outn 400.0
Mcs0 c0 vbn 0 0 nch w=1.5e-06 l=6e-06 m=1 delvto=0 mulu0=1
Mca0 d0 vcas c0 0 nch w=1e-06 l=5e-07 m=1 delvto=0 mulu0=1
Msp0 outn g0 d0 0 nch w=5e-07 l=1.8e-07 m=1 delvto=0 mulu0=1
Msn0 outp gb0 d0 0 nch w=5e-07 l=1.8e-07 m=1 delvto=0 mulu0=1
Vg0 g0 0 pwl(0 0 2e-08 0 2.02e-08 1.8 4e-08 1.8 4.02e-08 0 6e-08 0 6.02e-08 1.8 8e-08 1.8 8.02e-08 0 1e-07 0 1.002e-07 1.8 1.2e-07 1.8 1.202e-07 0 1.4e-07 0 1.402e-07 1.8 1.6e-07 1.8 1.602e-07 0 1.8e-07 0 1.802e-07 1.8 2e-07 1.8 2.002e-07 0 2.2e-07 0 2.202e-07 1.8 2.4e-07 1.8 2.402e-07 0 2.6e-07 0 2.602e-07 1.8 2.8e-07 1.8 2.802e-07 0 3e-07 0 3.002e-07 1.8 3.2e-07 1.8 3.202e-07 0 3.4e-07 0 3.402e-07 1.8 3.6e-07 1.8 3.602e-07 0 3.8e-07 0 3.802e-07 1.8 4e-07 1.8 4.002e-07 0 4.2e-07 0 4.202e-07 1.8 4.4e-07 1.8 4.402e-07 0 4.6e-07 0 4.602e-07 1.8 4.8e-07 1.8 4.802e-07 0 5e-07 0 5.002e-07 1.8 5.2e-07 1.8 5.202e-07 0 5.4e-07 0 5.402e-07 1.8 5.6e-07 1.8 5.602e-07 0 5.8e-07 0 5.802e-07 1.8 6e-07 1.8 6.002e-07 0 6.2e-07 0 6.202e-07 1.8 6.4e-07 1.8 6.402e-07 0 6.6e-07 0 6.602e-07 1.8 6.8e-07 1.8 6.802e-07 0 7e-07 0 7.002e-07 1.8 7.2e-07 1.8 7.202e-07 0 7.4e-07 0 7.402e-07 1.8 7.6e-07 1.8 7.602e-07 0 7.8e-07 0 7.802e-07 1.8 8e-07 1.8 8.002e-07 0 8.2e-07 0 8.202e-07 1.8 8.4e-07 1.8 8.402e-07 0 8.6e-07 0 8.602e-07 1.8 8.8e-07 1.8 8.802e-07 0 9e-07 0 9.002e-07 1.8 9.2e-07 1.8 9.202e-07 0 9.4e-07 0 9.402e-07 1.8 9.6e-07 1.8 9.602e-07 0 9.8e-07 0 9.802e-07 1.8 1e-06 1.8 1.0002e-06 0 1.02e-06 0 1.0202e-06 1.8 1.04e-06 1.8 1.0402e-06 0 1.06e-06 0 1.0602e-06 1.8 1.08e-06 1.8 1.0802e-06 0 1.1e-06 0 1.1002e-06 1.8 1.12e-06 1.8 1.1202e-06 0 1.14e-06 0 1.1402e-06 1.8 1.16e-06 1.8 1.1602e-06 0 1.18e-06 0 1.1802e-06 1.8 1.2e-06 1.8 1.2002e-06 0 1.22e-06 0 1.2202e-06 1.8 1.24e-06 1.8 1.2402e-06 0 1.26e-06 0 1.2602e-06 1.8 1.28e-06 1.8 1.2802e-06 0 1.3e-06 0 1.3002e-06 1.8 1.32e-06 1.8 1.3202e-06 0 1.34e-06 0 1.3402e-06 1.8 1.36e-06 1.8 1.3602e-06 0 1.38e-06 0 1.3802e-06 1.8 1.4e-06 1.8 1.4002e-06 0 1.42e-06 0 1.4202e-06 1.8 1.44e-06 1.8 1.4402e-06 0 1.46e-06 0 1.4602e-06 1.8 1.48e-06 1.8 1.4802e-06 0 1.5e-06 0 1.5002e-06 1.8 1.52e-06 1.8 1.5202e-06 0 1.54e-06 0 1.5402e-06 1.8 1.56e-06 1.8 1.5602e-06 0 1.58e-06 0 1.5802e-06 1.8 1.6e-06 1.8 1.6002e-06 0 1.62e-06 0 1.6202e-06 1.8 1.64e-06 1.8 1.6402e-06 0 1.66e-06 0 1.6602e-06 1.8 1.68e-06 1.8 1.6802e-06 0 1.7e-06 0 1.7002e-06 1.8 1.72e-06 1.8 1.7202e-06 0 1.74e-06 0 1.7402e-06 1.8 1.76e-06 1.8 1.7602e-06 0 1.78e-06 0 1.7802e-06 1.8 1.8e-06 1.8 1.8002e-06 0 1.82e-06 0 1.8202e-06 1.8 1.84e-06 1.8 1.8402e-06 0 1.86e-06 0 1.8602e-06 1.8 1.88e-06 1.8 1.8802e-06 0 1.9e-06 0 1.9002e-06 1.8 1.92e-06 1.8 1.9202e-06 0 1.94e-06 0 1.9402e-06 1.8 1.96e-06 1.8 1.9602e-06 0 1.98e-06 0 1.9802e-06 1.8 2e-06 1.8 2.0002e-06 0 2.02e-06 0 2.0202e-06 1.8 2.04e-06 1.8 2.0402e-06 0 2.06e-06 0 2.0602e-06 1.8 2.08e-06 1.8 2.0802e-06 0 2.1e-06 0 2.1002e-06 1.8 2.12e-06 1.8 2.1202e-06 0 2.14e-06 0 2.1402e-06 1.8 2.16e-06 1.8 2.1602e-06 0 2.18e-06 0 2.1802e-06 1.8 2.2e-06 1.8 2.2002e-06 0 2.22e-06 0 2.2202e-06 1.8 2.24e-06 1.8 2.2402e-06 0 2.26e-06 0 2.2602e-06 1.8 2.28e-06 1.8 2.2802e-06 0 2.3e-06 0 2.3002e-06 1.8 2.32e-06 1.8 2.3202e-06 0 2.34e-06 0 2.3402e-06 1.8 2.36e-06 1.8 2.3602e-06 0 2.38e-06 0 2.3802e-06 1.8 2.4e-06 1.8 2.4002e-06 0 2.42e-06 0 2.4202e-06 1.8 2.44e-06 1.8 2.4402e-06 0 2.46e-06 0 2.4602e-06 1.8 2.48e-06 1.8 2.4802e-06 0 2.5e-06 0 2.5002e-06 1.8 2.52e-06 1.8 2.5202e-06 0 2.54e-06 0 2.5402e-06 1.8 2.56e-06 1.8 2.5602e-06 0 2.58e-06 0 2.5802e-06 1.8 2.6e-06 1.8 2.6002e-06 0 2.62e-06 0 2.6202e-06 1.8 2.64e-06 1.8 2.6402e-06 0 2.66e-06 0 2.6602e-06 1.8 2.68e-06 1.8 2.6802e-06 0 2.7e-06 0 2.7002e-06 1.8 2.72e-06 1.8 2.7202e-06 0 2.74e-06 0 2.7402e-06 1.8 2.76e-06 1.8 2.7602e-06 0 2.78e-06 0 2.7802e-06 1.8 2.8e-06 1.8 2.8002e-06 0 2.82e-06 0 2.8202e-06 1.8 2.84e-06 1.8 2.8402e-06 0 2.86e-06 0 2.8602e-06 1.8 2.88e-06 1.8 2.8802e-06 0 2.9e-06 0 2.9002e-06 1.8 2.92e-06 1.8 2.9202e-06 0 2.94e-06 0 2.9402e-06 1.8 2.96e-06 1.8 2.9602e-06 0 2.98e-06 0 2.9802e-06 1.8 3e-06 1.8 3.0002e-06 0 3.02e-06 0 3.0202e-06 1.8 3.04e-06 1.8 3.0402e-06 0 3.06e-06 0 3.0602e-06 1.8 3.08e-06 1.8 3.0802e-06 0 3.1e-06 0 3.1002e-06 1.8 3.12e-06 1.8 3.1202e-06 0 3.14e-06 0 3.1402e-06 1.8 3.16e-06 1.8 3.1602e-06 0 3.18e-06 0 3.1802e-06 1.8 3.2e-06 1.8 3.2002e-06 0 3.22e-06 0 3.2202e-06 1.8 3.24e-06 1.8 3.2402e-06 0 3.26e-06 0 3.2602e-06 1.8 3.28e-06 1.8 3.2802e-06 0 3.3e-06 0 3.3002e-06 1.8 3.32e-06 1.8 3.3202e-06 0 3.34e-06 0 3.3402e-06 1.8 3.36e-06 1.8 3.3602e-06 0 3.38e-06 0 3.3802e-06 1.8 3.4e-06 1.8 3.4002e-06 0 3.42e-06 0 3.4202e-06 1.8 3.44e-06 1.8 3.4402e-06 0 3.46e-06 0 3.4602e-06 1.8 3.48e-06 1.8 3.4802e-06 0 3.5e-06 0 3.5002e-06 1.8 3.52e-06 1.8 3.5202e-06 0 3.54e-06 0 3.5402e-06 1.8 3.56e-06 1.8 3.5602e-06 0 3.58e-06 0 3.5802e-06 1.8 3.6e-06 1.8 3.6002e-06 0 3.62e-06 0 3.6202e-06 1.8 3.64e-06 1.8 3.6402e-06 0 3.66e-06 0 3.6602e-06 1.8 3.68e-06 1.8 3.6802e-06 0 3.7e-06 0 3.7002e-06 1.8 3.72e-06 1.8 3.7202e-06 0 3.74e-06 0 3.7402e-06 1.8 3.76e-06 1.8 3.7602e-06 0 3.78e-06 0 3.7802e-06 1.8 3.8e-06 1.8 3.8002e-06 0 3.82e-06 0 3.8202e-06 1.8 3.84e-06 1.8 3.8402e-06 0 3.86e-06 0 3.8602e-06 1.8 3.88e-06 1.8 3.8802e-06 0 3.9e-06 0 3.9002e-06 1.8 3.92e-06 1.8 3.9202e-06 0 3.94e-06 0 3.9402e-06 1.8 3.96e-06 1.8 3.9602e-06 0 3.98e-06 0 3.9802e-06 1.8 4e-06 1.8 4.0002e-06 0 4.02e-06 0 4.0202e-06 1.8 4.04e-06 1.8 4.0402e-06 0 4.06e-06 0 4.0602e-06 1.8 4.08e-06 1.8 4.0802e-06 0 4.1e-06 0 4.1002e-06 1.8 4.12e-06 1.8 4.1202e-06 0 4.14e-06 0 4.1402e-06 1.8 4.16e-06 1.8 4.1602e-06 0 4.18e-06 0 4.1802e-06 1.8 4.2e-06 1.8 4.2002e-06 0 4.22e-06 0 4.2202e-06 1.8 4.24e-06 1.8 4.2402e-06 0 4.26e-06 0 4.2602e-06 1.8 4.28e-06 1.8 4.2802e-06 0 4.3e-06 0 4.3002e-06 1.8 4.32e-06 1.8 4.3202e-06 0 4.34e-06 0 4.3402e-06 1.8 4.36e-06 1.8 4.3602e-06 0 4.38e-06 0 4.3802e-06 1.8 4.4e-06 1.8 4.4002e-06 0 4.42e-06 0 4.4202e-06 1.8 4.44e-06 1.8 4.4402e-06 0 4.46e-06 0 4.4602e-06 1.8 4.48e-06 1.8 4.4802e-06 0 4.5e-06 0 4.5002e-06 1.8 4.52e-06 1.8 4.5202e-06 0 4.54e-06 0 4.5402e-06 1.8 4.56e-06 1.8 4.5602e-06 0 4.58e-06 0 4.5802e-06 1.8 4.6e-06 1.8 4.6002e-06 0 4.62e-06 0 4.6202e-06 1.8 4.64e-06 1.8 4.6402e-06 0 4.66e-06 0 4.6602e-06 1.8 4.68e-06 1.8 4.6802e-06 0 4.7e-06 0 4.7002e-06 1.8 4.72e-06 1.8 4.7202e-06 0 4.74e-06 0 4.7402e-06 1.8 4.76e-06 1.8 4.7602e-06 0 4.78e-06 0 4.7802e-06 1.8 4.8e-06 1.8 4.8002e-06 0 4.82e-06 0 4.8202e-06 1.8 4.84e-06 1.8 4.8402e-06 0 4.86e-06 0 4.8602e-06 1.8 4.88e-06 1.8 4.8802e-06 0 4.9e-06 0 4.9002e-06 1.8 4.92e-06 1.8 4.9202e-06 0 4.94e-06 0 4.9402e-06 1.8 4.96e-06 1.8 4.9602e-06 0 4.98e-06 0 4.9802e-06 1.8 5e-06 1.8 5.0002e-06 0 5.02e-06 0 5.0202e-06 1.8 5.04e-06 1.8 5.0402e-06 0 5.06e-06 0 5.0602e-06 1.8 5.08e-06 1.8 5.0802e-06 0 5.1e-06 0 5.1002e-06 1.8)
Vgb0 gb0 0 pwl(0 1.8 2e-08 1.8 2.02e-08 0 4e-08 0 4.02e-08 1.8 6e-08 1.8 6.02e-08 0 8e-08 0 8.02e-08 1.8 1e-07 1.8 1.002e-07 0 1.2e-07 0 1.202e-07 1.8 1.4e-07 1.8 1.402e-07 0 1.6e-07 0 1.602e-07 1.8 1.8e-07 1.8 1.802e-07 0 2e-07 0 2.002e-07 1.8 2.2e-07 1.8 2.202e-07 0 2.4e-07 0 2.402e-07 1.8 2.6e-07 1.8 2.602e-07 0 2.8e-07 0 2.802e-07 1.8 3e-07 1.8 3.002e-07 0 3.2e-07 0 3.202e-07 1.8 3.4e-07 1.8 3.402e-07 0 3.6e-07 0 3.602e-07 1.8 3.8e-07 1.8 3.802e-07 0 4e-07 0 4.002e-07 1.8 4.2e-07 1.8 4.202e-07 0 4.4e-07 0 4.402e-07 1.8 4.6e-07 1.8 4.602e-07 0 4.8e-07 0 4.802e-07 1.8 5e-07 1.8 5.002e-07 0 5.2e-07 0 5.202e-07 1.8 5.4e-07 1.8 5.402e-07 0 5.6e-07 0 5.602e-07 1.8 5.8e-07 1.8 5.802e-07 0 6e-07 0 6.002e-07 1.8 6.2e-07 1.8 6.202e-07 0 6.4e-07 0 6.402e-07 1.8 6.6e-07 1.8 6.602e-07 0 6.8e-07 0 6.802e-07 1.8 7e-07 1.8 7.002e-07 0 7.2e-07 0 7.202e-07 1.8 7.4e-07 1.8 7.402e-07 0 7.6e-07 0 7.602e-07 1.8 7.8e-07 1.8 7.802e-07 0 8e-07 0 8.002e-07 1.8 8.2e-07 1.8 8.202e-07 0 8.4e-07 0 8.402e-07 1.8 8.6e-07 1.8 8.602e-07 0 8.8e-07 0 8.802e-07 1.8 9e-07 1.8 9.002e-07 0 9.2e-07 0 9.202e-07 1.8 9.4e-07 1.8 9.402e-07 0 9.6e-07 0 9.602e-07 1.8 9.8e-07 1.8 9.802e-07 0 1e-06 0 1.0002e-06 1.8 1.02e-06 1.8 1.0202e-06 0 1.04e-06 0 1.0402e-06 1.8 1.06e-06 1.8 1.0602e-06 0 1.08e-06 0 1.0802e-06 1.8 1.1e-06 1.8 1.1002e-06 0 1.12e-06 0 1.1202e-06 1.8 1.14e-06 1.8 1.1402e-06 0 1.16e-06 0 1.1602e-06 1.8 1.18e-06 1.8 1.1802e-06 0 1.2e-06 0 1.2002e-06 1.8 1.22e-06 1.8 1.2202e-06 0 1.24e-06 0 1.2402e-06 1.8 1.26e-06 1.8 1.2602e-06 0 1.28e-06 0 1.2802e-06 1.8 1.3e-06 1.8 1.3002e-06 0 1.32e-06 0 1.3202e-06 1.8 1.34e-06 1.8 1.3402e-06 0 1.36e-06 0 1.3602e-06 1.8 1.38e-06 1.8 1.3802e-06 0 1.4e-06 0 1.4002e-06 1.8 1.42e-06 1.8 1.4202e-06 0 1.44e-06 0 1.4402e-06 1.8 1.46e-06 1.8 1.4602e-06 0 1.48e-06 0 1.4802e-06 1.8 1.5e-06 1.8 1.5002e-06 0 1.52e-06 0 1.5202e-06 1.8 1.54e-06 1.8 1.5402e-06 0 1.56e-06 0 1.5602e-06 1.8 1.58e-06 1.8 1.5802e-06 0 1.6e-06 0 1.6002e-06 1.8 1.62e-06 1.8 1.6202e-06 0 1.64e-06 0 1.6402e-06 1.8 1.66e-06 1.8 1.6602e-06 0 1.68e-06 0 1.6802e-06 1.8 1.7e-06 1.8 1.7002e-06 0 1.72e-06 0 1.7202e-06 1.8 1.74e-06 1.8 1.7402e-06 0 1.76e-06 0 1.7602e-06 1.8 1.78e-06 1.8 1.7802e-06 0 1.8e-06 0 1.8002e-06 1.8 1.82e-06 1.8 1.8202e-06 0 1.84e-06 0 1.8402e-06 1.8 1.86e-06 1.8 1.8602e-06 0 1.88e-06 0 1.8802e-06 1.8 1.9e-06 1.8 1.9002e-06 0 1.92e-06 0 1.9202e-06 1.8 1.94e-06 1.8 1.9402e-06 0 1.96e-06 0 1.9602e-06 1.8 1.98e-06 1.8 1.9802e-06 0 2e-06 0 2.0002e-06 1.8 2.02e-06 1.8 2.0202e-06 0 2.04e-06 0 2.0402e-06 1.8 2.06e-06 1.8 2.0602e-06 0 2.08e-06 0 2.0802e-06 1.8 2.1e-06 1.8 2.1002e-06 0 2.12e-06 0 2.1202e-06 1.8 2.14e-06 1.8 2.1402e-06 0 2.16e-06 0 2.1602e-06 1.8 2.18e-06 1.8 2.1802e-06 0 2.2e-06 0 2.2002e-06 1.8 2.22e-06 1.8 2.2202e-06 0 2.24e-06 0 2.2402e-06 1.8 2.26e-06 1.8 2.2602e-06 0 2.28e-06 0 2.2802e-06 1.8 2.3e-06 1.8 2.3002e-06 0 2.32e-06 0 2.3202e-06 1.8 2.34e-06 1.8 2.3402e-06 0 2.36e-06 0 2.3602e-06 1.8 2.38e-06 1.8 2.3802e-06 0 2.4e-06 0 2.4002e-06 1.8 2.42e-06 1.8 2.4202e-06 0 2.44e-06 0 2.4402e-06 1.8 2.46e-06 1.8 2.4602e-06 0 2.48e-06 0 2.4802e-06 1.8 2.5e-06 1.8 2.5002e-06 0 2.52e-06 0 2.5202e-06 1.8 2.54e-06 1.8 2.5402e-06 0 2.56e-06 0 2.5602e-06 1.8 2.58e-06 1.8 2.5802e-06 0 2.6e-06 0 2.6002e-06 1.8 2.62e-06 1.8 2.6202e-06 0 2.64e-06 0 2.6402e-06 1.8 2.66e-06 1.8 2.6602e-06 0 2.68e-06 0 2.6802e-06 1.8 2.7e-06 1.8 2.7002e-06 0 2.72e-06 0 2.7202e-06 1.8 2.74e-06 1.8 2.7402e-06 0 2.76e-06 0 2.7602e-06 1.8 2.78e-06 1.8 2.7802e-06 0 2.8e-06 0 2.8002e-06 1.8 2.82e-06 1.8 2.8202e-06 0 2.84e-06 0 2.8402e-06 1.8 2.86e-06 1.8 2.8602e-06 0 2.88e-06 0 2.8802e-06 1.8 2.9e-06 1.8 2.9002e-06 0 2.92e-06 0 2.9202e-06 1.8 2.94e-06 1.8 2.9402e-06 0 2.96e-06 0 2.9602e-06 1.8 2.98e-06 1.8 2.9802e-06 0 3e-06 0 3.0002e-06 1.8 3.02e-06 1.8 3.0202e-06 0 3.04e-06 0 3.0402e-06 1.8 3.06e-06 1.8 3.0602e-06 0 3.08e-06 0 3.0802e-06 1.8 3.1e-06 1.8 3.1002e-06 0 3.12e-06 0 3.1202e-06 1.8 3.14e-06 1.8 3.1402e-06 0 3.16e-06 0 3.1602e-06 1.8 3.18e-06 1.8 3.1802e-06 0 3.2e-06 0 3.2002e-06 1.8 3.22e-06 1.8 3.2202e-06 0 3.24e-06 0 3.2402e-06 1.8 3.26e-06 1.8 3.2602e-06 0 3.28e-06 0 3.2802e-06 1.8 3.3e-06 1.8 3.3002e-06 0 3.32e-06 0 3.3202e-06 1.8 3.34e-06 1.8 3.3402e-06 0 3.36e-06 0 3.3602e-06 1.8 3.38e-06 1.8 3.3802e-06 0 3.4e-06 0 3.4002e-06 1.8 3.42e-06 1.8 3.4202e-06 0 3.44e-06 0 3.4402e-06 1.8 3.46e-06 1.8 3.4602e-06 0 3.48e-06 0 3.4802e-06 1.8 3.5e-06 1.8 3.5002e-06 0 3.52e-06 0 3.5202e-06 1.8 3.54e-06 1.8 3.5402e-06 0 3.56e-06 0 3.5602e-06 1.8 3.58e-06 1.8 3.5802e-06 0 3.6e-06 0 3.6002e-06 1.8 3.62e-06 1.8 3.6202e-06 0 3.64e-06 0 3.6402e-06 1.8 3.66e-06 1.8 3.6602e-06 0 3.68e-06 0 3.6802e-06 1.8 3.7e-06 1.8 3.7002e-06 0 3.72e-06 0 3.7202e-06 1.8 3.74e-06 1.8 3.7402e-06 0 3.76e-06 0 3.7602e-06 1.8 3.78e-06 1.8 3.7802e-06 0 3.8e-06 0 3.8002e-06 1.8 3.82e-06 1.8 3.8202e-06 0 3.84e-06 0 3.8402e-06 1.8 3.86e-06 1.8 3.8602e-06 0 3.88e-06 0 3.8802e-06 1.8 3.9e-06 1.8 3.9002e-06 0 3.92e-06 0 3.9202e-06 1.8 3.94e-06 1.8 3.9402e-06 0 3.96e-06 0 3.9602e-06 1.8 3.98e-06 1.8 3.9802e-06 0 4e-06 0 4.0002e-06 1.8 4.02e-06 1.8 4.0202e-06 0 4.04e-06 0 4.0402e-06 1.8 4.06e-06 1.8 4.0602e-06 0 4.08e-06 0 4.0802e-06 1.8 4.1e-06 1.8 4.1002e-06 0 4.12e-06 0 4.1202e-06 1.8 4.14e-06 1.8 4.1402e-06 0 4.16e-06 0 4.1602e-06 1.8 4.18e-06 1.8 4.1802e-06 0 4.2e-06 0 4.2002e-06 1.8 4.22e-06 1.8 4.2202e-06 0 4.24e-06 0 4.2402e-06 1.8 4.26e-06 1.8 4.2602e-06 0 4.28e-06 0 4.2802e-06 1.8 4.3e-06 1.8 4.3002e-06 0 4.32e-06 0 4.3202e-06 1.8 4.34e-06 1.8 4.3402e-06 0 4.36e-06 0 4.3602e-06 1.8 4.38e-06 1.8 4.3802e-06 0 4.4e-06 0 4.4002e-06 1.8 4.42e-06 1.8 4.4202e-06 0 4.44e-06 0 4.4402e-06 1.8 4.46e-06 1.8 4.4602e-06 0 4.48e-06 0 4.4802e-06 1.8 4.5e-06 1.8 4.5002e-06 0 4.52e-06 0 4.5202e-06 1.8 4.54e-06 1.8 4.5402e-06 0 4.56e-06 0 4.5602e-06 1.8 4.58e-06 1.8 4.5802e-06 0 4.6e-06 0 4.6002e-06 1.8 4.62e-06 1.8 4.6202e-06 0 4.64e-06 0 4.6402e-06 1.8 4.66e-06 1.8 4.6602e-06 0 4.68e-06 0 4.6802e-06 1.8 4.7e-06 1.8 4.7002e-06 0 4.72e-06 0 4.7202e-06 1.8 4.74e-06 1.8 4.7402e-06 0 4.76e-06 0 4.7602e-06 1.8 4.78e-06 1.8 4.7802e-06 0 4.8e-06 0 4.8002e-06 1.8 4.82e-06 1.8 4.8202e-06 0 4.84e-06 0 4.8402e-06 1.8 4.86e-06 1.8 4.8602e-06 0 4.88e-06 0 4.8802e-06 1.8 4.9e-06 1.8 4.9002e-06 0 4.92e-06 0 4.9202e-06 1.8 4.94e-06 1.8 4.9402e-06 0 4.96e-06 0 4.9602e-06 1.8 4.98e-06 1.8 4.9802e-06 0 5e-06 0 5.0002e-06 1.8 5.02e-06 1.8 5.0202e-06 0 5.04e-06 0 5.0402e-06 1.8 5.06e-06 1.8 5.0602e-06 0 5.08e-06 0 5.0802e-06 1.8 5.1e-06 1.8 5.1002e-06 0)
Mcs1 c1 vbn 0 0 nch w=1.5e-06 l=6e-06 m=2 delvto=0 mulu0=1
Mca1 d1 vcas c1 0 nch w=1e-06 l=5e-07 m=2 delvto=0 mulu0=1
Msp1 outn g1 d1 0 nch w=5e-07 l=1.8e-07 m=2 delvto=0 mulu0=1
Msn1 outp gb1 d1 0 nch w=5e-07 l=1.8e-07 m=2 delvto=0 mulu0=1
Vg1 g1 0 pwl(0 0 4e-08 0 4.02e-08 1.8 8e-08 1.8 8.02e-08 0 1.2e-07 0 1.202e-07 1.8 1.6e-07 1.8 1.602e-07 0 2e-07 0 2.002e-07 1.8 2.4e-07 1.8 2.402e-07 0 2.8e-07 0 2.802e-07 1.8 3.2e-07 1.8 3.202e-07 0 3.6e-07 0 3.602e-07 1.8 4e-07 1.8 4.002e-07 0 4.4e-07 0 4.402e-07 1.8 4.8e-07 1.8 4.802e-07 0 5.2e-07 0 5.202e-07 1.8 5.6e-07 1.8 5.602e-07 0 6e-07 0 6.002e-07 1.8 6.4e-07 1.8 6.402e-07 0 6.8e-07 0 6.802e-07 1.8 7.2e-07 1.8 7.202e-07 0 7.6e-07 0 7.602e-07 1.8 8e-07 1.8 8.002e-07 0 8.4e-07 0 8.402e-07 1.8 8.8e-07 1.8 8.802e-07 0 9.2e-07 0 9.202e-07 1.8 9.6e-07 1.8 9.602e-07 0 1e-06 0 1.0002e-06 1.8 1.04e-06 1.8 1.0402e-06 0 1.08e-06 0 1.0802e-06 1.8 1.12e-06 1.8 1.1202e-06 0 1.16e-06 0 1.1602e-06 1.8 1.2e-06 1.8 1.2002e-06 0 1.24e-06 0 1.2402e-06 1.8 1.28e-06 1.8 1.2802e-06 0 1.32e-06 0 1.3202e-06 1.8 1.36e-06 1.8 1.3602e-06 0 1.4e-06 0 1.4002e-06 1.8 1.44e-06 1.8 1.4402e-06 0 1.48e-06 0 1.4802e-06 1.8 1.52e-06 1.8 1.5202e-06 0 1.56e-06 0 1.5602e-06 1.8 1.6e-06 1.8 1.6002e-06 0 1.64e-06 0 1.6402e-06 1.8 1.68e-06 1.8 1.6802e-06 0 1.72e-06 0 1.7202e-06 1.8 1.76e-06 1.8 1.7602e-06 0 1.8e-06 0 1.8002e-06 1.8 1.84e-06 1.8 1.8402e-06 0 1.88e-06 0 1.8802e-06 1.8 1.92e-06 1.8 1.9202e-06 0 1.96e-06 0 1.9602e-06 1.8 2e-06 1.8 2.0002e-06 0 2.04e-06 0 2.0402e-06 1.8 2.08e-06 1.8 2.0802e-06 0 2.12e-06 0 2.1202e-06 1.8 2.16e-06 1.8 2.1602e-06 0 2.2e-06 0 2.2002e-06 1.8 2.24e-06 1.8 2.2402e-06 0 2.28e-06 0 2.2802e-06 1.8 2.32e-06 1.8 2.3202e-06 0 2.36e-06 0 2.3602e-06 1.8 2.4e-06 1.8 2.4002e-06 0 2.44e-06 0 2.4402e-06 1.8 2.48e-06 1.8 2.4802e-06 0 2.52e-06 0 2.5202e-06 1.8 2.56e-06 1.8 2.5602e-06 0 2.6e-06 0 2.6002e-06 1.8 2.64e-06 1.8 2.6402e-06 0 2.68e-06 0 2.6802e-06 1.8 2.72e-06 1.8 2.7202e-06 0 2.76e-06 0 2.7602e-06 1.8 2.8e-06 1.8 2.8002e-06 0 2.84e-06 0 2.8402e-06 1.8 2.88e-06 1.8 2.8802e-06 0 2.92e-06 0 2.9202e-06 1.8 2.96e-06 1.8 2.9602e-06 0 3e-06 0 3.0002e-06 1.8 3.04e-06 1.8 3.0402e-06 0 3.08e-06 0 3.0802e-06 1.8 3.12e-06 1.8 3.1202e-06 0 3.16e-06 0 3.1602e-06 1.8 3.2e-06 1.8 3.2002e-06 0 3.24e-06 0 3.2402e-06 1.8 3.28e-06 1.8 3.2802e-06 0 3.32e-06 0 3.3202e-06 1.8 3.36e-06 1.8 3.3602e-06 0 3.4e-06 0 3.4002e-06 1.8 3.44e-06 1.8 3.4402e-06 0 3.48e-06 0 3.4802e-06 1.8 3.52e-06 1.8 3.5202e-06 0 3.56e-06 0 3.5602e-06 1.8 3.6e-06 1.8 3.6002e-06 0 3.64e-06 0 3.6402e-06 1.8 3.68e-06 1.8 3.6802e-06 0 3.72e-06 0 3.7202e-06 1.8 3.76e-06 1.8 3.7602e-06 0 3.8e-06 0 3.8002e-06 1.8 3.84e-06 1.8 3.8402e-06 0 3.88e-06 0 3.8802e-06 1.8 3.92e-06 1.8 3.9202e-06 0 3.96e-06 0 3.9602e-06 1.8 4e-06 1.8 4.0002e-06 0 4.04e-06 0 4.0402e-06 1.8 4.08e-06 1.8 4.0802e-06 0 4.12e-06 0 4.1202e-06 1.8 4.16e-06 1.8 4.1602e-06 0 4.2e-06 0 4.2002e-06 1.8 4.24e-06 1.8 4.2402e-06 0 4.28e-06 0 4.2802e-06 1.8 4.32e-06 1.8 4.3202e-06 0 4.36e-06 0 4.3602e-06 1.8 4.4e-06 1.8 4.4002e-06 0 4.44e-06 0 4.4402e-06 1.8 4.48e-06 1.8 4.4802e-06 0 4.52e-06 0 4.5202e-06 1.8 4.56e-06 1.8 4.5602e-06 0 4.6e-06 0 4.6002e-06 1.8 4.64e-06 1.8 4.6402e-06 0 4.68e-06 0 4.6802e-06 1.8 4.72e-06 1.8 4.7202e-06 0 4.76e-06 0 4.7602e-06 1.8 4.8e-06 1.8 4.8002e-06 0 4.84e-06 0 4.8402e-06 1.8 4.88e-06 1.8 4.8802e-06 0 4.92e-06 0 4.9202e-06 1.8 4.96e-06 1.8 4.9602e-06 0 5e-06 0 5.0002e-06 1.8 5.04e-06 1.8 5.0402e-06 0 5.08e-06 0 5.0802e-06 1.8)
Vgb1 gb1 0 pwl(0 1.8 4e-08 1.8 4.02e-08 0 8e-08 0 8.02e-08 1.8 1.2e-07 1.8 1.202e-07 0 1.6e-07 0 1.602e-07 1.8 2e-07 1.8 2.002e-07 0 2.4e-07 0 2.402e-07 1.8 2.8e-07 1.8 2.802e-07 0 3.2e-07 0 3.202e-07 1.8 3.6e-07 1.8 3.602e-07 0 4e-07 0 4.002e-07 1.8 4.4e-07 1.8 4.402e-07 0 4.8e-07 0 4.802e-07 1.8 5.2e-07 1.8 5.202e-07 0 5.6e-07 0 5.602e-07 1.8 6e-07 1.8 6.002e-07 0 6.4e-07 0 6.402e-07 1.8 6.8e-07 1.8 6.802e-07 0 7.2e-07 0 7.202e-07 1.8 7.6e-07 1.8 7.602e-07 0 8e-07 0 8.002e-07 1.8 8.4e-07 1.8 8.402e-07 0 8.8e-07 0 8.802e-07 1.8 9.2e-07 1.8 9.202e-07 0 9.6e-07 0 9.602e-07 1.8 1e-06 1.8 1.0002e-06 0 1.04e-06 0 1.0402e-06 1.8 1.08e-06 1.8 1.0802e-06 0 1.12e-06 0 1.1202e-06 1.8 1.16e-06 1.8 1.1602e-06 0 1.2e-06 0 1.2002e-06 1.8 1.24e-06 1.8 1.2402e-06 0 1.28e-06 0 1.2802e-06 1.8 1.32e-06 1.8 1.3202e-06 0 1.36e-06 0 1.3602e-06 1.8 1.4e-06 1.8 1.4002e-06 0 1.44e-06 0 1.4402e-06 1.8 1.48e-06 1.8 1.4802e-06 0 1.52e-06 0 1.5202e-06 1.8 1.56e-06 1.8 1.5602e-06 0 1.6e-06 0 1.6002e-06 1.8 1.64e-06 1.8 1.6402e-06 0 1.68e-06 0 1.6802e-06 1.8 1.72e-06 1.8 1.7202e-06 0 1.76e-06 0 1.7602e-06 1.8 1.8e-06 1.8 1.8002e-06 0 1.84e-06 0 1.8402e-06 1.8 1.88e-06 1.8 1.8802e-06 0 1.92e-06 0 1.9202e-06 1.8 1.96e-06 1.8 1.9602e-06 0 2e-06 0 2.0002e-06 1.8 2.04e-06 1.8 2.0402e-06 0 2.08e-06 0 2.0802e-06 1.8 2.12e-06 1.8 2.1202e-06 0 2.16e-06 0 2.1602e-06 1.8 2.2e-06 1.8 2.2002e-06 0 2.24e-06 0 2.2402e-06 1.8 2.28e-06 1.8 2.2802e-06 0 2.32e-06 0 2.3202e-06 1.8 2.36e-06 1.8 2.3602e-06 0 2.4e-06 0 2.4002e-06 1.8 2.44e-06 1.8 2.4402e-06 0 2.48e-06 0 2.4802e-06 1.8 2.52e-06 1.8 2.5202e-06 0 2.56e-06 0 2.5602e-06 1.8 2.6e-06 1.8 2.6002e-06 0 2.64e-06 0 2.6402e-06 1.8 2.68e-06 1.8 2.6802e-06 0 2.72e-06 0 2.7202e-06 1.8 2.76e-06 1.8 2.7602e-06 0 2.8e-06 0 2.8002e-06 1.8 2.84e-06 1.8 2.8402e-06 0 2.88e-06 0 2.8802e-06 1.8 2.92e-06 1.8 2.9202e-06 0 2.96e-06 0 2.9602e-06 1.8 3e-06 1.8 3.0002e-06 0 3.04e-06 0 3.0402e-06 1.8 3.08e-06 1.8 3.0802e-06 0 3.12e-06 0 3.1202e-06 1.8 3.16e-06 1.8 3.1602e-06 0 3.2e-06 0 3.2002e-06 1.8 3.24e-06 1.8 3.2402e-06 0 3.28e-06 0 3.2802e-06 1.8 3.32e-06 1.8 3.3202e-06 0 3.36e-06 0 3.3602e-06 1.8 3.4e-06 1.8 3.4002e-06 0 3.44e-06 0 3.4402e-06 1.8 3.48e-06 1.8 3.4802e-06 0 3.52e-06 0 3.5202e-06 1.8 3.56e-06 1.8 3.5602e-06 0 3.6e-06 0 3.6002e-06 1.8 3.64e-06 1.8 3.6402e-06 0 3.68e-06 0 3.6802e-06 1.8 3.72e-06 1.8 3.7202e-06 0 3.76e-06 0 3.7602e-06 1.8 3.8e-06 1.8 3.8002e-06 0 3.84e-06 0 3.8402e-06 1.8 3.88e-06 1.8 3.8802e-06 0 3.92e-06 0 3.9202e-06 1.8 3.96e-06 1.8 3.9602e-06 0 4e-06 0 4.0002e-06 1.8 4.04e-06 1.8 4.0402e-06 0 4.08e-06 0 4.0802e-06 1.8 4.12e-06 1.8 4.1202e-06 0 4.16e-06 0 4.1602e-06 1.8 4.2e-06 1.8 4.2002e-06 0 4.24e-06 0 4.2402e-06 1.8 4.28e-06 1.8 4.2802e-06 0 4.32e-06 0 4.3202e-06 1.8 4.36e-06 1.8 4.3602e-06 0 4.4e-06 0 4.4002e-06 1.8 4.44e-06 1.8 4.4402e-06 0 4.48e-06 0 4.4802e-06 1.8 4.52e-06 1.8 4.5202e-06 0 4.56e-06 0 4.5602e-06 1.8 4.6e-06 1.8 4.6002e-06 0 4.64e-06 0 4.6402e-06 1.8 4.68e-06 1.8 4.6802e-06 0 4.72e-06 0 4.7202e-06 1.8 4.76e-06 1.8 4.7602e-06 0 4.8e-06 0 4.8002e-06 1.8 4.84e-06 1.8 4.8402e-06 0 4.88e-06 0 4.8802e-06 1.8 4.92e-06 1.8 4.9202e-06 0 4.96e-06 0 4.9602e-06 1.8 5e-06 1.8 5.0002e-06 0 5.04e-06 0 5.0402e-06 1.8 5.08e-06 1.8 5.0802e-06 0)
Mcs2 c2 vbn 0 0 nch w=1.5e-06 l=6e-06 m=4 delvto=0 mulu0=1
Mca2 d2 vcas c2 0 nch w=1e-06 l=5e-07 m=4 delvto=0 mulu0=1
Msp2 outn g2 d2 0 nch w=5e-07 l=1.8e-07 m=4 delvto=0 mulu0=1
Msn2 outp gb2 d2 0 nch w=5e-07 l=1.8e-07 m=4 delvto=0 mulu0=1
Vg2 g2 0 pwl(0 0 8e-08 0 8.02e-08 1.8 1.6e-07 1.8 1.602e-07 0 2.4e-07 0 2.402e-07 1.8 3.2e-07 1.8 3.202e-07 0 4e-07 0 4.002e-07 1.8 4.8e-07 1.8 4.802e-07 0 5.6e-07 0 5.602e-07 1.8 6.4e-07 1.8 6.402e-07 0 7.2e-07 0 7.202e-07 1.8 8e-07 1.8 8.002e-07 0 8.8e-07 0 8.802e-07 1.8 9.6e-07 1.8 9.602e-07 0 1.04e-06 0 1.0402e-06 1.8 1.12e-06 1.8 1.1202e-06 0 1.2e-06 0 1.2002e-06 1.8 1.28e-06 1.8 1.2802e-06 0 1.36e-06 0 1.3602e-06 1.8 1.44e-06 1.8 1.4402e-06 0 1.52e-06 0 1.5202e-06 1.8 1.6e-06 1.8 1.6002e-06 0 1.68e-06 0 1.6802e-06 1.8 1.76e-06 1.8 1.7602e-06 0 1.84e-06 0 1.8402e-06 1.8 1.92e-06 1.8 1.9202e-06 0 2e-06 0 2.0002e-06 1.8 2.08e-06 1.8 2.0802e-06 0 2.16e-06 0 2.1602e-06 1.8 2.24e-06 1.8 2.2402e-06 0 2.32e-06 0 2.3202e-06 1.8 2.4e-06 1.8 2.4002e-06 0 2.48e-06 0 2.4802e-06 1.8 2.56e-06 1.8 2.5602e-06 0 2.64e-06 0 2.6402e-06 1.8 2.72e-06 1.8 2.7202e-06 0 2.8e-06 0 2.8002e-06 1.8 2.88e-06 1.8 2.8802e-06 0 2.96e-06 0 2.9602e-06 1.8 3.04e-06 1.8 3.0402e-06 0 3.12e-06 0 3.1202e-06 1.8 3.2e-06 1.8 3.2002e-06 0 3.28e-06 0 3.2802e-06 1.8 3.36e-06 1.8 3.3602e-06 0 3.44e-06 0 3.4402e-06 1.8 3.52e-06 1.8 3.5202e-06 0 3.6e-06 0 3.6002e-06 1.8 3.68e-06 1.8 3.6802e-06 0 3.76e-06 0 3.7602e-06 1.8 3.84e-06 1.8 3.8402e-06 0 3.92e-06 0 3.9202e-06 1.8 4e-06 1.8 4.0002e-06 0 4.08e-06 0 4.0802e-06 1.8 4.16e-06 1.8 4.1602e-06 0 4.24e-06 0 4.2402e-06 1.8 4.32e-06 1.8 4.3202e-06 0 4.4e-06 0 4.4002e-06 1.8 4.48e-06 1.8 4.4802e-06 0 4.56e-06 0 4.5602e-06 1.8 4.64e-06 1.8 4.6402e-06 0 4.72e-06 0 4.7202e-06 1.8 4.8e-06 1.8 4.8002e-06 0 4.88e-06 0 4.8802e-06 1.8 4.96e-06 1.8 4.9602e-06 0 5.04e-06 0 5.0402e-06 1.8)
Vgb2 gb2 0 pwl(0 1.8 8e-08 1.8 8.02e-08 0 1.6e-07 0 1.602e-07 1.8 2.4e-07 1.8 2.402e-07 0 3.2e-07 0 3.202e-07 1.8 4e-07 1.8 4.002e-07 0 4.8e-07 0 4.802e-07 1.8 5.6e-07 1.8 5.602e-07 0 6.4e-07 0 6.402e-07 1.8 7.2e-07 1.8 7.202e-07 0 8e-07 0 8.002e-07 1.8 8.8e-07 1.8 8.802e-07 0 9.6e-07 0 9.602e-07 1.8 1.04e-06 1.8 1.0402e-06 0 1.12e-06 0 1.1202e-06 1.8 1.2e-06 1.8 1.2002e-06 0 1.28e-06 0 1.2802e-06 1.8 1.36e-06 1.8 1.3602e-06 0 1.44e-06 0 1.4402e-06 1.8 1.52e-06 1.8 1.5202e-06 0 1.6e-06 0 1.6002e-06 1.8 1.68e-06 1.8 1.6802e-06 0 1.76e-06 0 1.7602e-06 1.8 1.84e-06 1.8 1.8402e-06 0 1.92e-06 0 1.9202e-06 1.8 2e-06 1.8 2.0002e-06 0 2.08e-06 0 2.0802e-06 1.8 2.16e-06 1.8 2.1602e-06 0 2.24e-06 0 2.2402e-06 1.8 2.32e-06 1.8 2.3202e-06 0 2.4e-06 0 2.4002e-06 1.8 2.48e-06 1.8 2.4802e-06 0 2.56e-06 0 2.5602e-06 1.8 2.64e-06 1.8 2.6402e-06 0 2.72e-06 0 2.7202e-06 1.8 2.8e-06 1.8 2.8002e-06 0 2.88e-06 0 2.8802e-06 1.8 2.96e-06 1.8 2.9602e-06 0 3.04e-06 0 3.0402e-06 1.8 3.12e-06 1.8 3.1202e-06 0 3.2e-06 0 3.2002e-06 1.8 3.28e-06 1.8 3.2802e-06 0 3.36e-06 0 3.3602e-06 1.8 3.44e-06 1.8 3.4402e-06 0 3.52e-06 0 3.5202e-06 1.8 3.6e-06 1.8 3.6002e-06 0 3.68e-06 0 3.6802e-06 1.8 3.76e-06 1.8 3.7602e-06 0 3.84e-06 0 3.8402e-06 1.8 3.92e-06 1.8 3.9202e-06 0 4e-06 0 4.0002e-06 1.8 4.08e-06 1.8 4.0802e-06 0 4.16e-06 0 4.1602e-06 1.8 4.24e-06 1.8 4.2402e-06 0 4.32e-06 0 4.3202e-06 1.8 4.4e-06 1.8 4.4002e-06 0 4.48e-06 0 4.4802e-06 1.8 4.56e-06 1.8 4.5602e-06 0 4.64e-06 0 4.6402e-06 1.8 4.72e-06 1.8 4.7202e-06 0 4.8e-06 0 4.8002e-06 1.8 4.88e-06 1.8 4.8802e-06 0 4.96e-06 0 4.9602e-06 1.8 5.04e-06 1.8 5.0402e-06 0)
Mcs3 c3 vbn 0 0 nch w=1.5e-06 l=6e-06 m=8 delvto=0 mulu0=1
Mca3 d3 vcas c3 0 nch w=1e-06 l=5e-07 m=8 delvto=0 mulu0=1
Msp3 outn g3 d3 0 nch w=5e-07 l=1.8e-07 m=8 delvto=0 mulu0=1
Msn3 outp gb3 d3 0 nch w=5e-07 l=1.8e-07 m=8 delvto=0 mulu0=1
Vg3 g3 0 pwl(0 0 1.6e-07 0 1.602e-07 1.8 3.2e-07 1.8 3.202e-07 0 4.8e-07 0 4.802e-07 1.8 6.4e-07 1.8 6.402e-07 0 8e-07 0 8.002e-07 1.8 9.6e-07 1.8 9.602e-07 0 1.12e-06 0 1.1202e-06 1.8 1.28e-06 1.8 1.2802e-06 0 1.44e-06 0 1.4402e-06 1.8 1.6e-06 1.8 1.6002e-06 0 1.76e-06 0 1.7602e-06 1.8 1.92e-06 1.8 1.9202e-06 0 2.08e-06 0 2.0802e-06 1.8 2.24e-06 1.8 2.2402e-06 0 2.4e-06 0 2.4002e-06 1.8 2.56e-06 1.8 2.5602e-06 0 2.72e-06 0 2.7202e-06 1.8 2.88e-06 1.8 2.8802e-06 0 3.04e-06 0 3.0402e-06 1.8 3.2e-06 1.8 3.2002e-06 0 3.36e-06 0 3.3602e-06 1.8 3.52e-06 1.8 3.5202e-06 0 3.68e-06 0 3.6802e-06 1.8 3.84e-06 1.8 3.8402e-06 0 4e-06 0 4.0002e-06 1.8 4.16e-06 1.8 4.1602e-06 0 4.32e-06 0 4.3202e-06 1.8 4.48e-06 1.8 4.4802e-06 0 4.64e-06 0 4.6402e-06 1.8 4.8e-06 1.8 4.8002e-06 0 4.96e-06 0 4.9602e-06 1.8)
Vgb3 gb3 0 pwl(0 1.8 1.6e-07 1.8 1.602e-07 0 3.2e-07 0 3.202e-07 1.8 4.8e-07 1.8 4.802e-07 0 6.4e-07 0 6.402e-07 1.8 8e-07 1.8 8.002e-07 0 9.6e-07 0 9.602e-07 1.8 1.12e-06 1.8 1.1202e-06 0 1.28e-06 0 1.2802e-06 1.8 1.44e-06 1.8 1.4402e-06 0 1.6e-06 0 1.6002e-06 1.8 1.76e-06 1.8 1.7602e-06 0 1.92e-06 0 1.9202e-06 1.8 2.08e-06 1.8 2.0802e-06 0 2.24e-06 0 2.2402e-06 1.8 2.4e-06 1.8 2.4002e-06 0 2.56e-06 0 2.5602e-06 1.8 2.72e-06 1.8 2.7202e-06 0 2.88e-06 0 2.8802e-06 1.8 3.04e-06 1.8 3.0402e-06 0 3.2e-06 0 3.2002e-06 1.8 3.36e-06 1.8 3.3602e-06 0 3.52e-06 0 3.5202e-06 1.8 3.68e-06 1.8 3.6802e-06 0 3.84e-06 0 3.8402e-06 1.8 4e-06 1.8 4.0002e-06 0 4.16e-06 0 4.1602e-06 1.8 4.32e-06 1.8 4.3202e-06 0 4.48e-06 0 4.4802e-06 1.8 4.64e-06 1.8 4.6402e-06 0 4.8e-06 0 4.8002e-06 1.8 4.96e-06 1.8 4.9602e-06 0)
Mcs4 c4 vbn 0 0 nch w=1.5e-06 l=6e-06 m=16 delvto=0 mulu0=1
Mca4 d4 vcas c4 0 nch w=1e-06 l=5e-07 m=16 delvto=0 mulu0=1
Msp4 outn g4 d4 0 nch w=5e-07 l=1.8e-07 m=16 delvto=0 mulu0=1
Msn4 outp gb4 d4 0 nch w=5e-07 l=1.8e-07 m=16 delvto=0 mulu0=1
Vg4 g4 0 pwl(0 0 3.2e-07 0 3.202e-07 1.8)
Vgb4 gb4 0 pwl(0 1.8 3.2e-07 1.8 3.202e-07 0)
Mcs5 c5 vbn 0 0 nch w=1.5e-06 l=6e-06 m=16 delvto=0 mulu0=1
Mca5 d5 vcas c5 0 nch w=1e-06 l=5e-07 m=16 delvto=0 mulu0=1
Msp5 outn g5 d5 0 nch w=5e-07 l=1.8e-07 m=16 delvto=0 mulu0=1
Msn5 outp gb5 d5 0 nch w=5e-07 l=1.8e-07 m=16 delvto=0 mulu0=1
Vg5 g5 0 pwl(0 0 6.4e-07 0 6.402e-07 1.8)
Vgb5 gb5 0 pwl(0 1.8 6.4e-07 1.8 6.402e-07 0)
Mcs6 c6 vbn 0 0 nch w=1.5e-06 l=6e-06 m=16 delvto=0 mulu0=1
Mca6 d6 vcas c6 0 nch w=1e-06 l=5e-07 m=16 delvto=0 mulu0=1
Msp6 outn g6 d6 0 nch w=5e-07 l=1.8e-07 m=16 delvto=0 mulu0=1
Msn6 outp gb6 d6 0 nch w=5e-07 l=1.8e-07 m=16 delvto=0 mulu0=1
Vg6 g6 0 pwl(0 0 9.6e-07 0 9.602e-07 1.8)
Vgb6 gb6 0 pwl(0 1.8 9.6e-07 1.8 9.602e-07 0)
Mcs7 c7 vbn 0 0 nch w=1.5e-06 l=6e-06 m=16 delvto=0 mulu0=1
Mca7 d7 vcas c7 0 nch w=1e-06 l=5e-07 m=16 delvto=0 mulu0=1
Msp7 outn g7 d7 0 nch w=5e-07 l=1.8e-07 m=16 delvto=0 mulu0=1
Msn7 outp gb7 d7 0 nch w=5e-07 l=1.8e-07 m=16 delvto=0 mulu0=1
Vg7 g7 0 pwl(0 0 1.28e-06 0 1.2802e-06 1.8)
Vgb7 gb7 0 pwl(0 1.8 1.28e-06 1.8 1.2802e-06 0)
Mcs8 c8 vbn 0 0 nch w=1.5e-06 l=6e-06 m=16 delvto=0 mulu0=1
Mca8 d8 vcas c8 0 nch w=1e-06 l=5e-07 m=16 delvto=0 mulu0=1
Msp8 outn g8 d8 0 nch w=5e-07 l=1.8e-07 m=16 delvto=0 mulu0=1
Msn8 outp gb8 d8 0 nch w=5e-07 l=1.8e-07 m=16 delvto=0 mulu0=1
Vg8 g8 0 pwl(0 0 1.6e-06 0 1.6002e-06 1.8)
Vgb8 gb8 0 pwl(0 1.8 1.6e-06 1.8 1.6002e-06 0)
Mcs9 c9 vbn 0 0 nch w=1.5e-06 l=6e-06 m=16 delvto=0 mulu0=1
Mca9 d9 vcas c9 0 nch w=1e-06 l=5e-07 m=16 delvto=0 mulu0=1
Msp9 outn g9 d9 0 nch w=5e-07 l=1.8e-07 m=16 delvto=0 mulu0=1
Msn9 outp gb9 d9 0 nch w=5e-07 l=1.8e-07 m=16 delvto=0 mulu0=1
Vg9 g9 0 pwl(0 0 1.92e-06 0 1.9202e-06 1.8)
Vgb9 gb9 0 pwl(0 1.8 1.92e-06 1.8 1.9202e-06 0)
Mcs10 c10 vbn 0 0 nch w=1.5e-06 l=6e-06 m=16 delvto=0 mulu0=1
Mca10 d10 vcas c10 0 nch w=1e-06 l=5e-07 m=16 delvto=0 mulu0=1
Msp10 outn g10 d10 0 nch w=5e-07 l=1.8e-07 m=16 delvto=0 mulu0=1
Msn10 outp gb10 d10 0 nch w=5e-07 l=1.8e-07 m=16 delvto=0 mulu0=1
Vg10 g10 0 pwl(0 0 2.24e-06 0 2.2402e-06 1.8)
Vgb10 gb10 0 pwl(0 1.8 2.24e-06 1.8 2.2402e-06 0)
Mcs11 c11 vbn 0 0 nch w=1.5e-06 l=6e-06 m=16 delvto=0 mulu0=1
Mca11 d11 vcas c11 0 nch w=1e-06 l=5e-07 m=16 delvto=0 mulu0=1
Msp11 outn g11 d11 0 nch w=5e-07 l=1.8e-07 m=16 delvto=0 mulu0=1
Msn11 outp gb11 d11 0 nch w=5e-07 l=1.8e-07 m=16 delvto=0 mulu0=1
Vg11 g11 0 pwl(0 0 2.56e-06 0 2.5602e-06 1.8)
Vgb11 gb11 0 pwl(0 1.8 2.56e-06 1.8 2.5602e-06 0)
Mcs12 c12 vbn 0 0 nch w=1.5e-06 l=6e-06 m=16 delvto=0 mulu0=1
Mca12 d12 vcas c12 0 nch w=1e-06 l=5e-07 m=16 delvto=0 mulu0=1
Msp12 outn g12 d12 0 nch w=5e-07 l=1.8e-07 m=16 delvto=0 mulu0=1
Msn12 outp gb12 d12 0 nch w=5e-07 l=1.8e-07 m=16 delvto=0 mulu0=1
Vg12 g12 0 pwl(0 0 2.88e-06 0 2.8802e-06 1.8)
Vgb12 gb12 0 pwl(0 1.8 2.88e-06 1.8 2.8802e-06 0)
Mcs13 c13 vbn 0 0 nch w=1.5e-06 l=6e-06 m=16 delvto=0 mulu0=1
Mca13 d13 vcas c13 0 nch w=1e-06 l=5e-07 m=16 delvto=0 mulu0=1
Msp13 outn g13 d13 0 nch w=5e-07 l=1.8e-07 m=16 delvto=0 mulu0=1
Msn13 outp gb13 d13 0 nch w=5e-07 l=1.8e-07 m=16 delvto=0 mulu0=1
Vg13 g13 0 pwl(0 0 3.2e-06 0 3.2002e-06 1.8)
Vgb13 gb13 0 pwl(0 1.8 3.2e-06 1.8 3.2002e-06 0)
Mcs14 c14 vbn 0 0 nch w=1.5e-06 l=6e-06 m=16 delvto=0 mulu0=1
Mca14 d14 vcas c14 0 nch w=1e-06 l=5e-07 m=16 delvto=0 mulu0=1
Msp14 outn g14 d14 0 nch w=5e-07 l=1.8e-07 m=16 delvto=0 mulu0=1
Msn14 outp gb14 d14 0 nch w=5e-07 l=1.8e-07 m=16 delvto=0 mulu0=1
Vg14 g14 0 pwl(0 0 3.52e-06 0 3.5202e-06 1.8)
Vgb14 gb14 0 pwl(0 1.8 3.52e-06 1.8 3.5202e-06 0)
Mcs15 c15 vbn 0 0 nch w=1.5e-06 l=6e-06 m=16 delvto=0 mulu0=1
Mca15 d15 vcas c15 0 nch w=1e-06 l=5e-07 m=16 delvto=0 mulu0=1
Msp15 outn g15 d15 0 nch w=5e-07 l=1.8e-07 m=16 delvto=0 mulu0=1
Msn15 outp gb15 d15 0 nch w=5e-07 l=1.8e-07 m=16 delvto=0 mulu0=1
Vg15 g15 0 pwl(0 0 3.84e-06 0 3.8402e-06 1.8)
Vgb15 gb15 0 pwl(0 1.8 3.84e-06 1.8 3.8402e-06 0)
Mcs16 c16 vbn 0 0 nch w=1.5e-06 l=6e-06 m=16 delvto=0 mulu0=1
Mca16 d16 vcas c16 0 nch w=1e-06 l=5e-07 m=16 delvto=0 mulu0=1
Msp16 outn g16 d16 0 nch w=5e-07 l=1.8e-07 m=16 delvto=0 mulu0=1
Msn16 outp gb16 d16 0 nch w=5e-07 l=1.8e-07 m=16 delvto=0 mulu0=1
Vg16 g16 0 pwl(0 0 4.16e-06 0 4.1602e-06 1.8)
Vgb16 gb16 0 pwl(0 1.8 4.16e-06 1.8 4.1602e-06 0)
Mcs17 c17 vbn 0 0 nch w=1.5e-06 l=6e-06 m=16 delvto=0 mulu0=1
Mca17 d17 vcas c17 0 nch w=1e-06 l=5e-07 m=16 delvto=0 mulu0=1
Msp17 outn g17 d17 0 nch w=5e-07 l=1.8e-07 m=16 delvto=0 mulu0=1
Msn17 outp gb17 d17 0 nch w=5e-07 l=1.8e-07 m=16 delvto=0 mulu0=1
Vg17 g17 0 pwl(0 0 4.48e-06 0 4.4802e-06 1.8)
Vgb17 gb17 0 pwl(0 1.8 4.48e-06 1.8 4.4802e-06 0)
Mcs18 c18 vbn 0 0 nch w=1.5e-06 l=6e-06 m=16 delvto=0 mulu0=1
Mca18 d18 vcas c18 0 nch w=1e-06 l=5e-07 m=16 delvto=0 mulu0=1
Msp18 outn g18 d18 0 nch w=5e-07 l=1.8e-07 m=16 delvto=0 mulu0=1
Msn18 outp gb18 d18 0 nch w=5e-07 l=1.8e-07 m=16 delvto=0 mulu0=1
Vg18 g18 0 pwl(0 0 4.8e-06 0 4.8002e-06 1.8)
Vgb18 gb18 0 pwl(0 1.8 4.8e-06 1.8 4.8002e-06 0)

.control
set wr_vecnames
set wr_singlescale
option numdgt=10
tran 0.5n 5.12e-06 0 0.2n
let vd = v(outp) - v(outn)
linearize vd
wrdata dac_seg_ramp_tran.dat vd

.endc
.end
